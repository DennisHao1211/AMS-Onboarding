ADE simulation setup
Run mode: Single Run, Sweeps and Corners
Tests:
  AMS_Onboarding_Hanxiang_Hao_tb_res_1: AMS_Onboarding_Hanxiang_Hao/tb_res/schematic, simulator spectre
    Outputs: R0_sim; R1_sim; R2_sim
