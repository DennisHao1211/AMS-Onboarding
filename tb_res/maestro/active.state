ADE simulation setup
Test AMS_Onboarding_Hanxiang_Hao_tb_res_1: AMS_Onboarding_Hanxiang_Hao/tb_res/schematic, simulator spectre
  Models: /usr/scratch/hhao40/analog-onboarding-F26/PDK/sky130_release_0.0.9/models/sky130.lib.spice[tt]
  Temperature: 27
  Analysis dc: (saves the operating point)
  Output R0_sim = (1 / abs(IDC("/V0/PLUS")))
  Output R1_sim = (1 / abs(IDC("/V1/PLUS")))
  Output R2_sim = (1 / abs(IDC("/V2/PLUS")))
  Signals: /V0/PLUS (terminal), /V1/PLUS (terminal), /V2/PLUS (terminal)
Run mode: Single Run, Sweeps and Corners
