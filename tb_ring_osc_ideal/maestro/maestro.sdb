ADE simulation setup
Run mode: Single Run, Sweeps and Corners
Tests:
  AMS_Onboarding_Hanxiang_Hao_tb_ring_osc_1: AMS_Onboarding_Hanxiang_Hao/tb_ring_osc_ideal/schematic, simulator spectre
    Variables: Ic = 4u:1u:8u; Vin = 0.786
    Outputs: freq; tr; tf; duty; vmin; vmax; power; in_I2; out_I2; xn_I2; xp_I2
Corners (all switched off):
  model folders: /usr/scratch/hhao40/analog-onboarding-F26/PDK/sky130_release_0.0.9/models
  C0: temperature=0, 10, 20, 30, 40, 50, 60, 70; sky130.lib.spice[tt, ff, ss]
Specs:
  AMS_Onboarding_Hanxiang_Hao_tb_ring_osc_1 / freq: range 450M to 550M
  AMS_Onboarding_Hanxiang_Hao_tb_ring_osc_1 / tr: < 250p
  AMS_Onboarding_Hanxiang_Hao_tb_ring_osc_1 / tf: < 250p
  AMS_Onboarding_Hanxiang_Hao_tb_ring_osc_1 / duty: range 45 to 55
  AMS_Onboarding_Hanxiang_Hao_tb_ring_osc_1 / vmin: < 0.1
  AMS_Onboarding_Hanxiang_Hao_tb_ring_osc_1 / vmax: > 1.7
  AMS_Onboarding_Hanxiang_Hao_tb_ring_osc_1 / power: < 500u
