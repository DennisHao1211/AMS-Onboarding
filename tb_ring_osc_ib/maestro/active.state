ADE simulation setup
Test AMS_Onboarding_Hanxiang_Hao_tb_ring_osc_1: AMS_Onboarding_Hanxiang_Hao/tb_ring_osc_ib/schematic, simulator spectre
  Models: /usr/scratch/hhao40/analog-onboarding-F26/PDK/sky130_release_0.0.9/libs/sky130_fd_pr_main/../../models/sky130.lib.spice[tt]
  Variables: Iref = 6u
  Temperature: 27
  Analysis tran: stop=100n maxstep=2p skipdc=yes
  Output freq = frequency(clip(VT("/out") 2e-08 1e-07))
  Output tr = riseTime(clip(VT("/out") 2e-08 1e-07) 0 nil 1.8 nil 10 90 nil "time")
  Output tf = fallTime(clip(VT("/out") 2e-08 1e-07) 1.8 nil 0 nil 10 90 nil "time")
  Output duty = dutyCycle(clip(VT("/out") 2e-08 1e-07) ?mode "user" ?threshold 0.9 ?xName "time" ?outputType "average")
  Output vmin = ymin(clip(VT("/out") 2e-08 1e-07))
  Output vmax = ymax(clip(VT("/out") 2e-08 1e-07))
  Output power = (1.8 * abs(average(clip(IT("/Vmeas/PLUS") 2e-08 1e-07))))
  Output vbn = average(clip(VT("/I0/vbn") 2e-08 1e-07))
  Output vbp = average(clip(VT("/I0/vbp") 2e-08 1e-07))
  Signals: /out, /Vmeas/PLUS (terminal), /I0/vbn, /I0/vbp
Run mode: Single Run, Sweeps and Corners
Corners (all switched off):
  model folders: /usr/scratch/hhao40/analog-onboarding-F26/PDK/sky130_release_0.0.9/models
  C0: temperature=0, 10, 20, 30, 40, 50, 60, 70; sky130.lib.spice[tt ff ss]
Specs:
  AMS_Onboarding_Hanxiang_Hao_tb_ring_osc_1 / freq: range 450M to 550M
  AMS_Onboarding_Hanxiang_Hao_tb_ring_osc_1 / tr: < 250p
  AMS_Onboarding_Hanxiang_Hao_tb_ring_osc_1 / tf: < 250p
  AMS_Onboarding_Hanxiang_Hao_tb_ring_osc_1 / duty: range 45 to 55
  AMS_Onboarding_Hanxiang_Hao_tb_ring_osc_1 / vmin: < 0.1
  AMS_Onboarding_Hanxiang_Hao_tb_ring_osc_1 / vmax: > 1.7
  AMS_Onboarding_Hanxiang_Hao_tb_ring_osc_1 / power: < 500u
Setup values for test AMS_Onboarding_Hanxiang_Hao_tb_ring_osc_1: Vin = 1.44; s = 1; lcs = 0.5u
