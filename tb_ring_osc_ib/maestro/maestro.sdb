ADE simulation setup
Run mode: Single Run, Sweeps and Corners
Tests:
  AMS_Onboarding_Hanxiang_Hao_tb_ring_osc_1: AMS_Onboarding_Hanxiang_Hao/tb_ring_osc_ib/schematic, simulator spectre
    Variables: Vin = 1.44; s = 1; lcs = 0.5u
    Outputs: freq; tr; tf; duty; vmin; vmax; power; vbn; vbp
Corners (all switched off):
  model folders: /usr/scratch/hhao40/analog-onboarding-F26/PDK/sky130_release_0.0.9/models
  C0: temperature=0, 10, 20, 30, 40, 50, 60, 70; sky130.lib.spice[tt ff ss]
Specs:
  AMS_Onboarding_Hanxiang_Hao_tb_ring_osc_1 / freq: range 450M to 550M
  AMS_Onboarding_Hanxiang_Hao_tb_ring_osc_1 / tr: < 250p
  AMS_Onboarding_Hanxiang_Hao_tb_ring_osc_1 / tf: < 250p
  AMS_Onboarding_Hanxiang_Hao_tb_ring_osc_1 / duty: range 45 to 55
  AMS_Onboarding_Hanxiang_Hao_tb_ring_osc_1 / vmin: < 0.1
  AMS_Onboarding_Hanxiang_Hao_tb_ring_osc_1 / vmax: > 1.7
  AMS_Onboarding_Hanxiang_Hao_tb_ring_osc_1 / power: < 500u
